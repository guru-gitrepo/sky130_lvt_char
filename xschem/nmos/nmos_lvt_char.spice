** sch_path: /home/guru/Projects/sky130_lvt_char/xschem/nmos/nmos_lvt_char.sch
**.subckt nmos_lvt_char
XM1 net2 net1 0 0 sky130_fd_pr__nfet_01v8_lvt L={length} W=1 nf=1 ad=0.29 as=0.29 pd=2.58 ps=2.58 nrd=0.29 nrs=0.29 sa=0 sb=0 sd=0
+ mult=1
V1 net1 0 0.9
V2 net2 0 0.9
**** begin user architecture code

.include gm_id.sp

**** end user architecture code
**.ends
.end
